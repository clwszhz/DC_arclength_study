* 5 V source feeding a 1 kOhm resistor to ground.
* Expected: V(1)=5 V, I(V1)=-5 mA.
V1 1 0 5
R1 1 0 1000
.OP
.END
