* Same divider as the linear demo, solved through F(x)=0 and homotopy.
V1 1 0 10
R1 1 2 1000
R2 2 0 1000
.OP
.END
